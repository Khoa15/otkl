Lecture 4 - Full Wave Rectifier with  RL Load

.param RLoad = 10
.param LLoad = 200mH

Vs 2 1 sin(0 {300*sqrt(2)} 50Hz)
X1 2 1 3 0 fullbridge
LL 3 4 {LLoad} (IC=27A)
RL 4 0 {RLoad}

.subckt fullbridge sp sn lp ln
D1 sp lp dmod
D2 sn lp dmod
D3 ln sp dmod
D4 ln sn dmod
.model dmod D
.ends

.TRAN 0.01ms 80ms 0ms 0.01ms UIC
.PROBE
.END
